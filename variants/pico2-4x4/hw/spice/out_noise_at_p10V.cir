* output noise
.include models.lib
.param VREFV=2.5 CBV=1e-08
Vcc vcc 0 12.0
Vee vee 0 -12.0
Vcode code 0 DC 701 AC 1

Bref vref 0 V={VREFV}+V(rn)
Rrn rn 0 150820
Bdac dac 0 V=V(vref)*V(code)/65536+V(dn)
Rdn dn 0 603279
RT vref vb 10000
RB vb 0 8060
CB vb 0 {CBV}
R1 dac inn 10000
RF inn opo 82500
CF inn opo 4.7e-11
XU vb inn opo vcc vee OPA
Vmeas opo opo2 0
Dp opo2 vcc BAT54
Dn vee opo2 BAT54
RS opo2 jack 1000

RL jack 0 100000
.control
noise v(jack) Vcode dec 50 20 20k
setplot noise2
let tot = onoise_total
echo RES onoise = $&tot
.endc
.end
