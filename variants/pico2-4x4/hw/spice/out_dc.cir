* output DC transfer
.include models.lib
.param VREFV=2.5 CBV=1e-08
Vcc vcc 0 12.0
Vee vee 0 -12.0
Vcode code 0 DC 32768 AC 1

Bref vref 0 V={VREFV}+V(rn)
Rrn rn 0 150820
Bdac dac 0 V=V(vref)*V(code)/65536+V(dn)
Rdn dn 0 603279
RT vref vb 10000
RB vb 0 8060
CB vb 0 {CBV}
R1 dac inn 10000
RF inn opo 82500
CF inn opo 4.7e-11
XU vb inn opo vcc vee OPA
Vmeas opo opo2 0
Dp opo2 vcc BAT54
Dn vee opo2 BAT54
RS opo2 jack 1000

RL jack 0 100000
.control
dc Vcode 0 65535 4096
let j0 = v(jack)[0]
echo RES jack_0 = $&j0
let j1 = v(jack)[1]
echo RES jack_1 = $&j1
let j2 = v(jack)[2]
echo RES jack_2 = $&j2
let j3 = v(jack)[3]
echo RES jack_3 = $&j3
let j4 = v(jack)[4]
echo RES jack_4 = $&j4
let j5 = v(jack)[5]
echo RES jack_5 = $&j5
let j6 = v(jack)[6]
echo RES jack_6 = $&j6
let j7 = v(jack)[7]
echo RES jack_7 = $&j7
let j8 = v(jack)[8]
echo RES jack_8 = $&j8
let j9 = v(jack)[9]
echo RES jack_9 = $&j9
let j10 = v(jack)[10]
echo RES jack_10 = $&j10
let j11 = v(jack)[11]
echo RES jack_11 = $&j11
let j12 = v(jack)[12]
echo RES jack_12 = $&j12
let j13 = v(jack)[13]
echo RES jack_13 = $&j13
let j14 = v(jack)[14]
echo RES jack_14 = $&j14
let j15 = v(jack)[15]
echo RES jack_15 = $&j15
let j16 = v(jack)[16]
echo RES jack_16 = $&j16
.endc
.end
